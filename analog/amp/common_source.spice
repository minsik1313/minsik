* common_source.spice
*
* Single-stage common-source amplifier — flow-demonstration deck for the
* ngspice-in-the-loop sizing automation (docs/FABLESS_PLAN.md §2.5).
*
* Uses a generic Level-1 NMOS so it runs WITHOUT a PDK. For real design,
* delete the .model line and instead include the sky130 device models, e.g.:
*   .lib $PDK_ROOT/sky130A/libs.tech/ngspice/sky130.lib.spice tt
* and instantiate sky130_fd_pr__nfet_01v8.

.param W=10u L=1u Rd=10k Vsupply=1.8 Vbias=0.7

Vdd   vdd 0 {Vsupply}
Vin   in  0 dc {Vbias} ac 1
M1    out in 0 0 nch W={W} L={L}
Rd    vdd out {Rd}

.model nch nmos (level=1 kp=120u vto=0.5 lambda=0.05)

.control
  ac dec 20 1 1G
  meas ac gain_db max vdb(out)
  print gain_db
.endc
.end
