* ============================================================
* 5-Transistor OTA (5T amplifier)
*   - NMOS input differential pair : M1, M2
*   - PMOS current-mirror load      : M3, M4
*   - NMOS tail current source      : M5
*   - tail bias generated by a resistor + diode branch (R1, D1)
*
* MOSFET : M<name> <drain> <gate> <source> <bulk> <model> [params]
* RES    : R<name> <n1> <n2> <value>
* ============================================================

* --- input differential pair (NMOS) ---
M1  OUTM  INP   TAIL  VSS  nmos  W=4u  L=0.5u
M2  OUTP  INN   TAIL  VSS  nmos  W=4u  L=0.5u

* --- current-mirror load (PMOS), M3 diode-connected ---
M3  OUTM  OUTM  VDD   VDD  pmos  W=8u  L=0.5u
M4  OUTP  OUTM  VDD   VDD  pmos  W=8u  L=0.5u

* --- tail current source (NMOS), biased by VBIAS ---
M5  TAIL  VBIAS VSS   VSS  nmos  W=8u  L=0.5u

* --- bias branch: resistor + diode-connected NMOS set VBIAS ---
*     MB1 is diode-connected (gate tied to drain); mirrors into M5
R1   VDD   VBIAS  50k
MB1  VBIAS VBIAS  VSS   VSS  nmos  W=8u  L=0.5u

* --- device models ---
.model nmos  nmos
.model pmos  pmos

* --- supplies ---
.global VDD VSS
.end
