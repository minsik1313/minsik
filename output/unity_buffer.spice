.subckt unity_buffer VDD VSS VREF VOUT IBIAS
* ---- bias mirror (NMOS): reference, tail source, output preload ----
XMB0 IBIAS IBIAS VSS VSS sky130_fd_pr__nfet_01v8 L=0.5 W=10.0 nf=1 m=2
XMB1 TAIL IBIAS VSS VSS sky130_fd_pr__nfet_01v8 L=0.5 W=10.0 nf=1 m=4
XMBPRE VOUT IBIAS VSS VSS sky130_fd_pr__nfet_01v8 L=0.5 W=10.0 nf=1 m=20
* ---- NMOS input pair (M1.g=VOUT feedback, M2.g=VREF) ----
XM1 NA VOUT TAIL VSS sky130_fd_pr__nfet_01v8 L=0.5 W=10.0 nf=1 m=4
XM2 OTA VREF TAIL VSS sky130_fd_pr__nfet_01v8 L=0.5 W=10.0 nf=1 m=4
* ---- PMOS current-mirror load ----
XM3 NA NA VDD VDD sky130_fd_pr__pfet_01v8 L=1.0 W=7.0 nf=1 m=32
XM4 OTA NA VDD VDD sky130_fd_pr__pfet_01v8 L=1.0 W=7.0 nf=1 m=32
* ---- PMOS pass device ----
XMP VOUT OTA VDD VDD sky130_fd_pr__pfet_01v8 L=0.25 W=5.0 nf=4 m=65
.ends unity_buffer
